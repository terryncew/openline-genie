* MIF-PWS v2 Physical Experiment 004 - 4x4 Heater, RTD & 4-Wire Kelvin Coaxial PDN Netlist
* Compatible with ngspice / LTspice / Xyce
.PARAM V_HEATER=24.0 I_PDN_TOTAL=50.0 R_SHUNT=0.0001
V_THERM_SUPPLY N_HVDD 0 DC {V_HEATER}
I_PDN_SOURCE 0 N_PDN_IN DC {I_PDN_TOTAL}
R_REF_SHUNT N_PDN_IN N_BUS_RING 0.0001
* Tile (0,0) Coaxial Busbar Post + Kelvin Sense + Heater + Pt100 RTD
R_COAX_VDD_Q0_0 N_BUS_RING N_DIE_VDD_Q0_0 0.000211
R_COAX_GND_Q0_0 N_DIE_VDD_Q0_0 0 0.000211
R_KELVIN_SENSE_HI_Q0_0 N_DIE_VDD_Q0_0 N_KHI_Q0_0 1000.0
R_KELVIN_SENSE_LO_Q0_0 0 N_KLO_Q0_0 1000.0
R_HEATER_Q0_0 N_HVDD 0 15.0
R_RTD_PT100_Q0_0 N_RTD_HI_Q0_0 0 113.5
* Tile (0,1) Coaxial Busbar Post + Kelvin Sense + Heater + Pt100 RTD
R_COAX_VDD_Q0_1 N_BUS_RING N_DIE_VDD_Q0_1 0.000211
R_COAX_GND_Q0_1 N_DIE_VDD_Q0_1 0 0.000211
R_KELVIN_SENSE_HI_Q0_1 N_DIE_VDD_Q0_1 N_KHI_Q0_1 1000.0
R_KELVIN_SENSE_LO_Q0_1 0 N_KLO_Q0_1 1000.0
R_HEATER_Q0_1 N_HVDD 0 15.0
R_RTD_PT100_Q0_1 N_RTD_HI_Q0_1 0 113.5
* Tile (0,2) Coaxial Busbar Post + Kelvin Sense + Heater + Pt100 RTD
R_COAX_VDD_Q0_2 N_BUS_RING N_DIE_VDD_Q0_2 0.000211
R_COAX_GND_Q0_2 N_DIE_VDD_Q0_2 0 0.000211
R_KELVIN_SENSE_HI_Q0_2 N_DIE_VDD_Q0_2 N_KHI_Q0_2 1000.0
R_KELVIN_SENSE_LO_Q0_2 0 N_KLO_Q0_2 1000.0
R_HEATER_Q0_2 N_HVDD 0 15.0
R_RTD_PT100_Q0_2 N_RTD_HI_Q0_2 0 113.5
* Tile (0,3) Coaxial Busbar Post + Kelvin Sense + Heater + Pt100 RTD
R_COAX_VDD_Q0_3 N_BUS_RING N_DIE_VDD_Q0_3 0.000211
R_COAX_GND_Q0_3 N_DIE_VDD_Q0_3 0 0.000211
R_KELVIN_SENSE_HI_Q0_3 N_DIE_VDD_Q0_3 N_KHI_Q0_3 1000.0
R_KELVIN_SENSE_LO_Q0_3 0 N_KLO_Q0_3 1000.0
R_HEATER_Q0_3 N_HVDD 0 15.0
R_RTD_PT100_Q0_3 N_RTD_HI_Q0_3 0 113.5
* Tile (1,0) Coaxial Busbar Post + Kelvin Sense + Heater + Pt100 RTD
R_COAX_VDD_Q1_0 N_BUS_RING N_DIE_VDD_Q1_0 0.000211
R_COAX_GND_Q1_0 N_DIE_VDD_Q1_0 0 0.000211
R_KELVIN_SENSE_HI_Q1_0 N_DIE_VDD_Q1_0 N_KHI_Q1_0 1000.0
R_KELVIN_SENSE_LO_Q1_0 0 N_KLO_Q1_0 1000.0
R_HEATER_Q1_0 N_HVDD 0 15.0
R_RTD_PT100_Q1_0 N_RTD_HI_Q1_0 0 113.5
* Tile (1,1) Coaxial Busbar Post + Kelvin Sense + Heater + Pt100 RTD
R_COAX_VDD_Q1_1 N_BUS_RING N_DIE_VDD_Q1_1 0.000211
R_COAX_GND_Q1_1 N_DIE_VDD_Q1_1 0 0.000211
R_KELVIN_SENSE_HI_Q1_1 N_DIE_VDD_Q1_1 N_KHI_Q1_1 1000.0
R_KELVIN_SENSE_LO_Q1_1 0 N_KLO_Q1_1 1000.0
R_HEATER_Q1_1 N_HVDD 0 15.0
R_RTD_PT100_Q1_1 N_RTD_HI_Q1_1 0 113.5
* Tile (1,2) Coaxial Busbar Post + Kelvin Sense + Heater + Pt100 RTD
R_COAX_VDD_Q1_2 N_BUS_RING N_DIE_VDD_Q1_2 0.000211
R_COAX_GND_Q1_2 N_DIE_VDD_Q1_2 0 0.000211
R_KELVIN_SENSE_HI_Q1_2 N_DIE_VDD_Q1_2 N_KHI_Q1_2 1000.0
R_KELVIN_SENSE_LO_Q1_2 0 N_KLO_Q1_2 1000.0
R_HEATER_Q1_2 N_HVDD 0 15.0
R_RTD_PT100_Q1_2 N_RTD_HI_Q1_2 0 113.5
* Tile (1,3) Coaxial Busbar Post + Kelvin Sense + Heater + Pt100 RTD
R_COAX_VDD_Q1_3 N_BUS_RING N_DIE_VDD_Q1_3 0.000211
R_COAX_GND_Q1_3 N_DIE_VDD_Q1_3 0 0.000211
R_KELVIN_SENSE_HI_Q1_3 N_DIE_VDD_Q1_3 N_KHI_Q1_3 1000.0
R_KELVIN_SENSE_LO_Q1_3 0 N_KLO_Q1_3 1000.0
R_HEATER_Q1_3 N_HVDD 0 15.0
R_RTD_PT100_Q1_3 N_RTD_HI_Q1_3 0 113.5
* Tile (2,0) Coaxial Busbar Post + Kelvin Sense + Heater + Pt100 RTD
R_COAX_VDD_Q2_0 N_BUS_RING N_DIE_VDD_Q2_0 0.000211
R_COAX_GND_Q2_0 N_DIE_VDD_Q2_0 0 0.000211
R_KELVIN_SENSE_HI_Q2_0 N_DIE_VDD_Q2_0 N_KHI_Q2_0 1000.0
R_KELVIN_SENSE_LO_Q2_0 0 N_KLO_Q2_0 1000.0
R_HEATER_Q2_0 N_HVDD 0 15.0
R_RTD_PT100_Q2_0 N_RTD_HI_Q2_0 0 113.5
* Tile (2,1) Coaxial Busbar Post + Kelvin Sense + Heater + Pt100 RTD
R_COAX_VDD_Q2_1 N_BUS_RING N_DIE_VDD_Q2_1 0.000211
R_COAX_GND_Q2_1 N_DIE_VDD_Q2_1 0 0.000211
R_KELVIN_SENSE_HI_Q2_1 N_DIE_VDD_Q2_1 N_KHI_Q2_1 1000.0
R_KELVIN_SENSE_LO_Q2_1 0 N_KLO_Q2_1 1000.0
R_HEATER_Q2_1 N_HVDD 0 15.0
R_RTD_PT100_Q2_1 N_RTD_HI_Q2_1 0 113.5
* Tile (2,2) Coaxial Busbar Post + Kelvin Sense + Heater + Pt100 RTD
R_COAX_VDD_Q2_2 N_BUS_RING N_DIE_VDD_Q2_2 0.000211
R_COAX_GND_Q2_2 N_DIE_VDD_Q2_2 0 0.000211
R_KELVIN_SENSE_HI_Q2_2 N_DIE_VDD_Q2_2 N_KHI_Q2_2 1000.0
R_KELVIN_SENSE_LO_Q2_2 0 N_KLO_Q2_2 1000.0
R_HEATER_Q2_2 N_HVDD 0 15.0
R_RTD_PT100_Q2_2 N_RTD_HI_Q2_2 0 113.5
* Tile (2,3) Coaxial Busbar Post + Kelvin Sense + Heater + Pt100 RTD
R_COAX_VDD_Q2_3 N_BUS_RING N_DIE_VDD_Q2_3 0.000211
R_COAX_GND_Q2_3 N_DIE_VDD_Q2_3 0 0.000211
R_KELVIN_SENSE_HI_Q2_3 N_DIE_VDD_Q2_3 N_KHI_Q2_3 1000.0
R_KELVIN_SENSE_LO_Q2_3 0 N_KLO_Q2_3 1000.0
R_HEATER_Q2_3 N_HVDD 0 15.0
R_RTD_PT100_Q2_3 N_RTD_HI_Q2_3 0 113.5
* Tile (3,0) Coaxial Busbar Post + Kelvin Sense + Heater + Pt100 RTD
R_COAX_VDD_Q3_0 N_BUS_RING N_DIE_VDD_Q3_0 0.000211
R_COAX_GND_Q3_0 N_DIE_VDD_Q3_0 0 0.000211
R_KELVIN_SENSE_HI_Q3_0 N_DIE_VDD_Q3_0 N_KHI_Q3_0 1000.0
R_KELVIN_SENSE_LO_Q3_0 0 N_KLO_Q3_0 1000.0
R_HEATER_Q3_0 N_HVDD 0 15.0
R_RTD_PT100_Q3_0 N_RTD_HI_Q3_0 0 113.5
* Tile (3,1) Coaxial Busbar Post + Kelvin Sense + Heater + Pt100 RTD
R_COAX_VDD_Q3_1 N_BUS_RING N_DIE_VDD_Q3_1 0.000211
R_COAX_GND_Q3_1 N_DIE_VDD_Q3_1 0 0.000211
R_KELVIN_SENSE_HI_Q3_1 N_DIE_VDD_Q3_1 N_KHI_Q3_1 1000.0
R_KELVIN_SENSE_LO_Q3_1 0 N_KLO_Q3_1 1000.0
R_HEATER_Q3_1 N_HVDD 0 15.0
R_RTD_PT100_Q3_1 N_RTD_HI_Q3_1 0 113.5
* Tile (3,2) Coaxial Busbar Post + Kelvin Sense + Heater + Pt100 RTD
R_COAX_VDD_Q3_2 N_BUS_RING N_DIE_VDD_Q3_2 0.000211
R_COAX_GND_Q3_2 N_DIE_VDD_Q3_2 0 0.000211
R_KELVIN_SENSE_HI_Q3_2 N_DIE_VDD_Q3_2 N_KHI_Q3_2 1000.0
R_KELVIN_SENSE_LO_Q3_2 0 N_KLO_Q3_2 1000.0
R_HEATER_Q3_2 N_HVDD 0 15.0
R_RTD_PT100_Q3_2 N_RTD_HI_Q3_2 0 113.5
* Tile (3,3) Coaxial Busbar Post + Kelvin Sense + Heater + Pt100 RTD
R_COAX_VDD_Q3_3 N_BUS_RING N_DIE_VDD_Q3_3 0.000211
R_COAX_GND_Q3_3 N_DIE_VDD_Q3_3 0 0.000211
R_KELVIN_SENSE_HI_Q3_3 N_DIE_VDD_Q3_3 N_KHI_Q3_3 1000.0
R_KELVIN_SENSE_LO_Q3_3 0 N_KLO_Q3_3 1000.0
R_HEATER_Q3_3 N_HVDD 0 15.0
R_RTD_PT100_Q3_3 N_RTD_HI_Q3_3 0 113.5
.OP
.END
